;--------------------------
; Program  : skill-oo(libs/load.il)
; Language : Cadence Skill
;--------------------------

; Load the namespace registry first (no dependencies), then ycIO (no
; dependencies), then bootstrap ycPathLib - the loop below needs
; ycPathLib::CurrentFile, and Path->open returns ycIO::Port.
let((t_self t_dir)
    t_self = get_filename(piport)
    unless(pcreMatchp("/" t_self)
        t_self = strcat("./" t_self)
    )
    t_dir = pcreReplace(pcreCompile("(?<=/)[^/]+/*$") t_self "" 0)
    load(strcat(t_dir "registry.il"))
    load(strcat(t_dir "io/load.il"))
    load(strcat(t_dir "pathlib/load.il"))
)

; pathlib stays outside the loop because the loop itself depends on it;
; every other package goes through the list below (one dir per entry,
; each must contain a load.il).
let((t_dir t_pkgs)
    t_dir = ycPathLib::CurrentFile()->parent()
    t_pkgs = list(
        "lang"
        "regex"
        "subprocess"
        "codec"
        "utf8"
        "string"
        "units"
        "radix"
        "geom"
        "textwrap"
        "tabulate"
        "datetime"
        "log"
    )
    foreach(t_pkg t_pkgs
        t_dir->join(t_pkg "load.il")->load()
    )
)

; END
