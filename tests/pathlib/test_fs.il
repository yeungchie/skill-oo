let((t_tmp p_base)

t_tmp = "ycPathlibTmpTest"
system(strcat("rm -rf " t_tmp))

p_base = _p(t_tmp)
_assert(!p_base->exists()  "fixture: clean before start")

; --- mkdir ---
p_base->mkdir()
_assert(p_base->isDir()  "mkdir: creates directory")
_assert(p_base->exists()  "exists: after mkdir")
_assertError(lambda(() p_base->mkdir() t)  "mkdir: existing directory errors")
p_base->mkdir(?existOk t)
_assert(p_base->isDir()  "mkdir: existOk silent")

let((p_deep)
    p_deep = p_base->join("a")->join("b")->join("c")
    _assertError(lambda(() p_deep->mkdir() t)  "mkdir: missing parent errors")
    p_deep->mkdir(?parents t)
    _assert(p_deep->isDir()  "mkdir: parents recursive")
    _assert(p_base->join("a")->isDir()  "mkdir: parents creates intermediate")
)

; --- writeText / readText ---
let((p_f)
    p_f = p_base->join("hello.txt")
    p_f->writeText("Hello ycPathLib\nline2\n")
    _assert(p_f->exists()  "writeText: creates file")
    _assert(p_f->isFile()  "isFile: file")
    _assert(!p_f->isDir()  "isDir: file is not dir")
    _assert(p_f->readText() == "Hello ycPathLib\nline2\n"  "readText: roundtrip keeps newlines")
    p_f->writeText("x")
    _assert(p_f->readText() == "x"  "writeText: truncates existing")
    _assertError(lambda(() p_base->join("missing.txt")->readText() t)  "readText: missing file errors")
    _assertError(lambda(() p_base->join("nope")->join("x.txt")->writeText("y") t)  "writeText: missing parent errors")
)

; --- size / mtime ---
let((p_f)
    p_f = p_base->join("hello.txt")
    _assert(p_f->size() == 1  "size: file size")
    _assert(numberp(p_f->mtime()) && p_f->mtime() > 0  "mtime: file mtime positive")
    _assert(numberp(p_base->mtime())  "mtime: dir mtime number")
    _assertError(lambda(() p_base->join("missing.txt")->size() t)  "size: missing file errors")
    _assertError(lambda(() p_base->join("missing.txt")->mtime() t)  "mtime: missing file errors")
)

; --- iterdir ---
let((p_sub l_names)
    p_sub = p_base->join("sub")
    p_sub->mkdir()
    _assertError(lambda(() p_base->join("hello.txt")->iterdir() t)  "iterdir: non-directory errors")
    l_names = _sl(p_base->iterdir())
    _assert(length(l_names) == 3  "iterdir: three entries")
    _assert(_hasStr(l_names p_base->join("hello.txt")->str())  "iterdir: includes file")
    _assert(_hasStr(l_names p_sub->str())  "iterdir: includes subdir")
    _assert(_hasStr(l_names p_base->join("a")->str())  "iterdir: includes tree")
    _assert(!_hasStr(l_names ".")  "iterdir: no dot entry")
    _assert(!_hasStr(l_names "..")  "iterdir: no dotdot entry")
)

; --- glob ---
let((p_f p_sub)
    p_f = p_base->join("sub")->join("deep.txt")
    p_sub = p_base->join("sub")
    p_f->writeText("deep")

    _assertSameStrs(_sl(p_base->glob("*.txt"))
        list(p_base->join("hello.txt")->str())
        "glob: *.txt top level")
    _assertSameStrs(_sl(p_base->glob("**/*.txt"))
        list(p_base->join("hello.txt")->str() p_f->str())
        "glob: **/*.txt zero level and nested")
    _assertSameStrs(_sl(p_base->glob("**"))
        list(p_base->str()
             p_base->join("a")->str()
             p_base->join("a/b")->str()
             p_base->join("a/b/c")->str()
             p_sub->str()
             p_base->join("hello.txt")->str()
             p_f->str())
        "glob: ** yields files and dirs including self")
    _assertSameStrs(_sl(p_base->glob("**/"))
        list(p_base->str()
             p_base->join("a")->str()
             p_base->join("a/b")->str()
             p_base->join("a/b/c")->str()
             p_sub->str())
        "glob: **/ dirs only")
    _assertSameStrs(_sl(p_base->rglob("*.txt"))
        list(p_base->join("hello.txt")->str() p_f->str())
        "rglob: *.txt recursive")
    _assertSameStrs(_sl(p_base->rglob(""))
        list(p_base->str()
             p_base->join("a")->str()
             p_base->join("a/b")->str()
             p_base->join("a/b/c")->str()
             p_sub->str())
        "rglob: empty pattern yields terminal ** dirs (CPython same)")
    _assertSameStrs(_sl(p_base->glob("*"))
        list(p_base->join("a")->str()
             p_base->join("hello.txt")->str()
             p_sub->str())
        "glob: star includes files")
    _assertSameStrs(_sl(p_base->glob("*/"))
        list(p_base->join("a")->str() p_sub->str())
        "glob: trailing slash dirs only")
    _assertSameStrs(_sl(p_base->glob("a/"))
        list(p_base->join("a")->str())
        "glob: literal trailing slash")
    _assertSameStrs(_sl(p_base->glob("hello.txt/"))
        nil
        "glob: file with trailing slash empty")
    _assertSameStrs(_sl(p_base->glob("*/*"))
        list(p_base->join("a/b")->str() p_f->str())
        "glob: two levels")
    _assertSameStrs(_sl(p_base->glob("**/c"))
        list(p_base->join("a/b/c")->str())
        "glob: recursive literal")
    _assertSameStrs(_sl(p_base->glob("b/*"))
        nil
        "glob: missing literal dir empty")
    _assertSameStrs(_sl(p_base->glob("sub/../hello.txt"))
        list(p_base->join("sub/../hello.txt")->str())
        "glob: dotdot segment textual")
    _assertSameStrs(_sl(p_base->glob(".."))
        list(p_base->join("..")->str())
        "glob: dotdot terminal")
    _assertError(lambda(() p_base->glob(".") t)  "glob: dot pattern errors")
    _assertSameStrs(_sl(p_base->join("hello.txt")->glob("*"))
        nil
        "glob: file base empty")
    _assertError(lambda(() p_base->glob("") t)  "glob: empty pattern errors")
    _assertError(lambda(() p_base->glob("/abs/*") t)  "glob: absolute pattern errors")
    let((l_r)
        l_r = errset(_sl(p_base->glob("a**")) t)
        _assert(l_r  "glob: partial ** does not error")
        when(l_r
            _assertSameStrs(car(l_r)
                list(p_base->join("a")->str())
                "glob: partial ** acts as single star")
        )
    )
    let((l_r)
        l_r = errset(_sl(p_base->glob("**txt")) t)
        _assert(l_r  "glob: leading partial ** does not error")
        when(l_r
            _assertSameStrs(car(l_r)
                list(p_base->join("hello.txt")->str())
                "glob: leading partial ** acts as single star")
        )
    )
    _assertError(lambda(() p_base->rglob("/abs") t)  "rglob: absolute pattern errors")
    _assertError(lambda(() p_base->glob("./") t)  "glob: dot-slash pattern errors")
    _assertSameStrs(_sl(p_base->glob("./hello.txt"))
        list(p_base->join("hello.txt")->str())
        "glob: dot segment dropped")
    _assertSameStrs(_sl(p_base->glob("[ab]"))
        list(p_base->join("a")->str())
        "glob: char class single")
    _assertSameStrs(_sl(p_base->glob("[!a]*"))
        list(p_base->join("hello.txt")->str() p_sub->str())
        "glob: negated char class")
    _assertSameStrs(_sl(p_base->glob("*.tx[ty]"))
        list(p_base->join("hello.txt")->str())
        "glob: char class")
    _assertSameStrs(_sl(p_base->glob("*.tx[yz]"))
        nil
        "glob: char class miss")
    _assertSameStrs(_sl(p_base->glob("sub/../hello.txt/.."))
        nil
        "glob: dotdot after file empty")
)

; --- glob: leading-dot names NOT special (pathlib aligned) ---
let((p_hf p_hd p_sub p_f)
    p_sub = p_base->join("sub")
    p_f = p_sub->join("deep.txt")
    p_hf = p_base->join(".hidden.txt")
    p_hd = p_base->join(".hdir")
    p_hf->writeText("h")
    p_hd->mkdir()
    p_hd->join("inner.txt")->writeText("i")

    _assertSameStrs(_sl(p_base->glob("*"))
        list(p_base->join("a")->str()
             p_base->join("hello.txt")->str()
             p_sub->str()
             p_hf->str()
             p_hd->str())
        "glob: star matches leading-dot names too")
    _assertSameStrs(_sl(p_base->glob(".*"))
        list(p_hf->str() p_hd->str())
        "glob: dot-star matches leading-dot names")
    _assertSameStrs(_sl(p_base->glob("**"))
        list(p_base->str()
             p_base->join("a")->str()
             p_base->join("a/b")->str()
             p_base->join("a/b/c")->str()
             p_sub->str()
             p_hd->str()
             p_base->join("hello.txt")->str()
             p_f->str()
             p_hf->str()
             p_hd->join("inner.txt")->str())
        "glob: ** sees dot dirs, dot files and nested files")
    _assertSameStrs(_sl(p_base->glob("**/"))
        list(p_base->str()
             p_base->join("a")->str()
             p_base->join("a/b")->str()
             p_base->join("a/b/c")->str()
             p_sub->str()
             p_hd->str())
        "glob: **/ dirs only including dot dirs")
    _assertSameStrs(_sl(p_base->rglob("*.txt"))
        list(p_base->join("hello.txt")->str()
             p_f->str()
             p_hf->str()
             p_hd->join("inner.txt")->str())
        "rglob: includes leading-dot names")
    _assertSameStrs(_sl(p_base->glob("**/*.txt"))
        list(p_base->join("hello.txt")->str()
             p_f->str()
             p_hf->str()
             p_hd->join("inner.txt")->str())
        "glob: **/*.txt includes leading-dot dir contents")
    _assert(length(_sl(p_base->iterdir())) == 5  "iterdir: includes leading-dot names")
)

; --- module entry ---
let((p_wd)
    p_wd = ycPathLib::cwd()
    _assert(p_wd->isAbsolute()  "cwd: absolute")
    _assert(p_wd->exists()  "cwd: exists")
    _assert(p_wd->str() == _s(getWorkingDir())  "cwd: matches getWorkingDir")
)
let((t_home)
    t_home = getShellEnvVar("HOME")
    when(stringp(t_home) && t_home != ""
        _assert(ycPathLib::home()->str() == _s(t_home)  "home: matches HOME env")
    )
)

; --- readable / writable / executable ---
let((p_f p_miss)
    p_f = p_base->join("hello.txt")
    p_miss = p_base->join("no-such-entry")
    _assert(p_f->readable()  "readable: file is readable")
    _assert(p_f->writable()  "writable: file is writable")
    _assert(!p_f->executable()  "executable: text file not executable")
    _assert(p_base->executable()  "executable: dir is executable")
    _assert(p_base->writable()  "writable: dir is writable")
    _assert(!p_miss->readable()  "readable: missing -> nil")
    _assert(!p_miss->writable()  "writable: missing -> nil")
    _assert(!p_miss->executable()  "executable: missing -> nil")
)

; --- load / loadi ---
; The in-file runtime error path (load propagates, loadi does not) is NOT
; tested here: load holds the erroring file open, so deleting it on an NFS
; mount leaves an unremovable .nfsXXXX silly-rename file. That difference is
; left uncovered by this suite.
let((p_ok p_miss)
    p_ok = p_base->join("load_ok.il")
    p_miss = p_base->join("no-such-load.il")
    p_ok->writeText("_TestLoadSeen = t\n")

    _TestLoadSeen = nil
    _assert(p_ok->load() == t  "load: returns t")
    _assert(_TestLoadSeen == t  "load: executes the file")
    _TestLoadSeen = nil
    _assert(p_ok->loadi() == t  "loadi: returns t")
    _assert(_TestLoadSeen == t  "loadi: executes the file")
    _TestLoadSeen = nil
    _assert(p_ok->load(nil) == t  "load: nil password == omitted")
    _assert(p_ok->load("pw") == t  "load: password string accepted on plain file")

    _assertError(lambda(() p_ok->load(42) t)  "load: non-string password errors")
    _assertError(lambda(() p_ok->loadi(42) t)  "loadi: non-string password errors")
    _assertError(lambda(() p_miss->load() t)  "load: missing file errors")
    _assertError(lambda(() p_miss->loadi() t)  "loadi: missing file errors")
    _assertError(lambda(() p_base->load() t)  "load: directory errors")
    _assertError(lambda(() p_base->loadi() t)  "loadi: directory errors")

    p_ok->unlink()
)

; --- rename ---
let((p_src p_dst)
    p_src = p_base->join("hello.txt")
    p_dst = p_base->join("renamed.txt")
    p_src->rename(p_dst)
    _assert(!p_src->exists() && p_dst->exists()  "rename: moves file")
    p_dst->rename(p_src)
    _assert(p_src->exists() && !p_dst->exists()  "rename: moves file back")
    _assertError(lambda(() p_src->rename(42) t)  "rename: bad target errors")
    _assertError(lambda(() p_base->join("ghost.txt")->rename(p_src->str()) t)  "rename: missing source errors")
    _assertError(lambda(() p_src->rename(p_base->join("a")->str()) t)  "rename: target dir errors")
)

; --- touch ---
; CPython Path.touch() bumps mtime via os.utime on existing files. The old
; outfile("a")+close-without-write form left st_mtime unchanged on POSIX, so
; touch() now shells out to touch(1) (like rename uses mv).
; system("sleep 1.1") avoids a false pass from whole-second mtime resolution;
; SKILL has no sleep builtin, so this shells out like the rm/ln calls above.
let((p_t t_before t_after)
    p_t = p_base->join("touched.txt")
    p_t->touch()
    _assert(p_t->exists() && p_t->isFile()  "touch: creates file")
    p_t->writeText("keep")
    p_t->touch()
    _assert(p_t->readText() == "keep"  "touch: preserves content")
    _assertError(lambda(() p_base->touch() t)  "touch: directory errors")
    t_before = p_t->mtime()
    system("sleep 1.1")
    p_t->touch()
    t_after = p_t->mtime()
    _assert(t_after > t_before  "touch: updates mtime of existing file (CPython updates)")
    _assert(p_t->readText() == "keep"  "touch: content preserved after mtime bump")
)
when(isFileName("/proc/version")
    _assertError(lambda(() _p("/proc/version")->touch() t)  "touch: unwritable target errors")
)

; --- open ---
let((g_port)
    g_port = p_base->join("hello.txt")->open(?mode "r")
    _assert(g_port != nil  "open: read mode returns port")
    when(g_port
        close(g_port)
    )
    _assertError(lambda(() p_base->join("hello.txt")->open(?mode "b") t)  "open: invalid mode errors")
    _assertError(lambda(() p_base->join("missing.txt")->open(?mode "r") t)  "open: missing file errors")
)

; --- resolve (real files, symlink safe) ---
let((p_f)
    p_f = p_base->join("hello.txt")
    _assert(p_base->join("sub")->join("..")->join("hello.txt")->resolve()->str()
        == p_f->resolve()->str()
        "resolve: collapses dotdot on real paths")
    _assert(_p("/")->resolve()->str() == "/"  "resolve: root")
)

; --- unlink ---
let((p_t)
    p_t = p_base->join("touched.txt")
    p_t->unlink()
    _assert(!p_t->exists()  "unlink: removes file")
    _assertError(lambda(() p_t->unlink() t)  "unlink: missing file errors")
    p_t->unlink(?missingOk t)
    _assert(!p_t->exists()  "unlink: missingOk silent")
    _assertError(lambda(() p_base->unlink() t)  "unlink: directory errors")
)

; --- rmdir ---
let((p_bc)
    p_bc = p_base->join("a")->join("b")
    _assertError(lambda(() p_bc->rmdir() t)  "rmdir: non-empty errors")
    p_bc->join("c")->rmdir()
    _assert(!p_bc->join("c")->exists()  "rmdir: removes empty dir")
    _assertError(lambda(() p_bc->join("c")->rmdir() t)  "rmdir: missing dir errors")
    _assertError(lambda(() p_base->join("no-such-dir")->rmdir() t)  "rmdir: never-created errors")
)

; --- symlink ---
let((p_tfile p_tdir p_link p_moved p_dirlnk p_broken)
    p_tfile = p_base->join("hello.txt")
    p_tdir = p_base->join("sub")
    p_link = p_base->join("link.txt")
    p_moved = p_base->join("moved.txt")
    p_dirlnk = p_base->join("linkdir")
    system(lsprintf("ln -s hello.txt %s/link.txt" p_base->str()))
    system(lsprintf("ln -s sub %s/linkdir" p_base->str()))
    _assert(p_link->isSymlink() && p_dirlnk->isSymlink()  "symlink: isSymlink true")
    _assert(!p_tfile->isSymlink() && !p_tdir->isSymlink()  "symlink: real entries not symlink")
    _assert(p_link->exists() && p_link->isFile()  "symlink: follows to target file")
    _assert(p_link->size() == p_tfile->size()  "symlink: size follows target")
    _assert(p_link->mtime() == p_tfile->mtime()  "symlink: mtime follows target")
    _assertSameStrs(_sl(p_base->glob("**"))
        list(p_base->str()
             p_base->join("a")->str()
             p_base->join("a/b")->str()
             p_tdir->str()
             p_dirlnk->str()
             p_tfile->str()
             p_tdir->join("deep.txt")->str()
             p_base->join(".hidden.txt")->str()
             p_base->join(".hdir")->str()
             p_base->join(".hdir/inner.txt")->str()
             p_link->str())
        "symlink: glob ** yields link dir entry but does not enter it")
    _assertSameStrs(_sl(p_base->glob("**/"))
        list(p_base->str()
             p_base->join("a")->str()
             p_base->join("a/b")->str()
             p_tdir->str()
             p_base->join(".hdir")->str())
        "symlink: **/ dirs only excludes link dir")
    _assertSameStrs(_sl(p_base->rglob("*.txt"))
        list(p_tfile->str()
             p_tdir->join("deep.txt")->str()
             p_link->str()
             p_base->join(".hidden.txt")->str()
             p_base->join(".hdir/inner.txt")->str())
        "symlink: rglob sees link name but not link dir contents")
    _assert(p_link->readable()  "readable: symlink follows target")
    _assert(p_link->writable()  "writable: symlink follows target")
    _assert(!p_link->executable()  "executable: symlink follows target (not executable)")
    p_link->rename(p_moved)
    _assert(!p_link->isSymlink() && p_moved->isSymlink() && p_tfile->exists()  "symlink: rename moves the link itself")
    p_moved->unlink()
    _assert(!p_moved->exists() && !p_moved->isSymlink() && p_tfile->exists()  "symlink: unlink removes link keeps target")
    p_broken = p_base->join("broken")
    system(lsprintf("ln -s no-such-target %s/broken" p_base->str()))
    _assert(p_broken->isSymlink()  "symlink: broken link isSymlink")
    _assert(!p_broken->exists()  "symlink: broken link exists false")
    _assertError(lambda(() p_broken->size() t)  "symlink: broken link size errors")
    _assertError(lambda(() p_broken->mtime() t)  "symlink: broken link mtime errors")
    _assert(!p_broken->readable()  "readable: broken symlink -> nil")
    _assert(!p_broken->writable()  "writable: broken symlink -> nil")
    _assert(!p_broken->executable()  "executable: broken symlink -> nil")
)

; --- size() on a directory ---
; CPython Path.stat().st_size on a directory is a number (real dir size).
; size() only checks exists(), which is also true for directories, so the
; call returns the directory's real byte size (a number).
let((l_r)
    l_r = errset(p_base->size() t)
    _assert(l_r && numberp(car(l_r))  "size: directory returns a number (CPython stat().st_size)")
)

; --- cleanup ---
system(strcat("rm -rf " t_tmp))
_assert(!p_base->exists()  "fixture: cleanup")

)  ; end let

_TestFsDone = t

; END
