let((tmp p_base)

tmp = "ycPathlibTmpTest"
system(strcat("rm -rf " tmp))

p_base = _P(tmp)
_Assert(!p_base->exists()  "fixture: clean before start")

; --- mkdir ---
p_base->mkdir()
_Assert(p_base->isDir()  "mkdir: creates directory")
_Assert(p_base->exists()  "exists: after mkdir")
_AssertError(lambda(() p_base->mkdir() t)  "mkdir: existing directory errors")
p_base->mkdir(?existOk t)
_Assert(p_base->isDir()  "mkdir: existOk silent")

let((p_deep)
    p_deep = p_base->join("a")->join("b")->join("c")
    _AssertError(lambda(() p_deep->mkdir() t)  "mkdir: missing parent errors")
    p_deep->mkdir(?parents t)
    _Assert(p_deep->isDir()  "mkdir: parents recursive")
    _Assert(p_base->join("a")->isDir()  "mkdir: parents creates intermediate")
)

; --- writeText / readText ---
let((p_f)
    p_f = p_base->join("hello.txt")
    p_f->writeText("Hello ycPathLib\nline2\n")
    _Assert(p_f->exists()  "writeText: creates file")
    _Assert(p_f->isFile()  "isFile: file")
    _Assert(!p_f->isDir()  "isDir: file is not dir")
    _Assert(p_f->readText() == "Hello ycPathLib\nline2\n"  "readText: roundtrip keeps newlines")
    p_f->writeText("x")
    _Assert(p_f->readText() == "x"  "writeText: truncates existing")
    _AssertError(lambda(() p_base->join("missing.txt")->readText() t)  "readText: missing file errors")
    _AssertError(lambda(() p_base->join("nope")->join("x.txt")->writeText("y") t)  "writeText: missing parent errors")
)

; --- size / mtime ---
let((p_f)
    p_f = p_base->join("hello.txt")
    _Assert(p_f->size() == 1  "size: file size")
    _Assert(numberp(p_f->mtime()) && p_f->mtime() > 0  "mtime: file mtime positive")
    _Assert(numberp(p_base->mtime())  "mtime: dir mtime number")
    _AssertError(lambda(() p_base->join("missing.txt")->size() t)  "size: missing file errors")
    _AssertError(lambda(() p_base->join("missing.txt")->mtime() t)  "mtime: missing file errors")
)

; --- iterdir ---
let((p_sub names)
    p_sub = p_base->join("sub")
    p_sub->mkdir()
    _AssertError(lambda(() p_base->join("hello.txt")->iterdir() t)  "iterdir: non-directory errors")
    names = _Sl(p_base->iterdir())
    _Assert(length(names) == 3  "iterdir: three entries")
    _Assert(_HasStr(names p_base->join("hello.txt")->str())  "iterdir: includes file")
    _Assert(_HasStr(names p_sub->str())  "iterdir: includes subdir")
    _Assert(_HasStr(names p_base->join("a")->str())  "iterdir: includes tree")
    _Assert(!_HasStr(names ".")  "iterdir: no dot entry")
    _Assert(!_HasStr(names "..")  "iterdir: no dotdot entry")
)

; --- glob ---
let((p_f p_sub)
    p_f = p_base->join("sub")->join("deep.txt")
    p_sub = p_base->join("sub")
    p_f->writeText("deep")

    _AssertSameStrs(_Sl(p_base->glob("*.txt"))
        list(p_base->join("hello.txt")->str())
        "glob: *.txt top level")
    _AssertSameStrs(_Sl(p_base->glob("**/*.txt"))
        list(p_base->join("hello.txt")->str() p_f->str())
        "glob: **/*.txt zero level and nested")
    _AssertSameStrs(_Sl(p_base->glob("**"))
        list(p_base->str()
             p_base->join("a")->str()
             p_base->join("a/b")->str()
             p_base->join("a/b/c")->str()
             p_sub->str()
             p_base->join("hello.txt")->str()
             p_f->str())
        "glob: ** yields files and dirs including self")
    _AssertSameStrs(_Sl(p_base->glob("**/"))
        list(p_base->str()
             p_base->join("a")->str()
             p_base->join("a/b")->str()
             p_base->join("a/b/c")->str()
             p_sub->str())
        "glob: **/ dirs only")
    _AssertSameStrs(_Sl(p_base->rglob("*.txt"))
        list(p_base->join("hello.txt")->str() p_f->str())
        "rglob: *.txt recursive")
    _AssertSameStrs(_Sl(p_base->rglob(""))
        list(p_base->str()
             p_base->join("a")->str()
             p_base->join("a/b")->str()
             p_base->join("a/b/c")->str()
             p_sub->str())
        "rglob: empty pattern yields terminal ** dirs (CPython same)")
    _AssertSameStrs(_Sl(p_base->rglob("."))
        _Sl(p_base->glob("**"))
        "rglob: dot equals glob **")
    _AssertSameStrs(_Sl(p_base->rglob("")),
        _Sl(p_base->glob("**/"))
        "rglob: empty equals glob **/")
    _AssertSameStrs(_Sl(p_base->rglob("./")),
        _Sl(p_base->glob("**/"))
        "rglob: dot-slash equals glob **/")
    _AssertSameStrs(_Sl(p_base->glob("**/**")),
        _Sl(p_base->glob("**"))
        "glob: consecutive ** collapses")
    _AssertSameStrs(_Sl(p_base->glob("*"))
        list(p_base->join("a")->str()
             p_base->join("hello.txt")->str()
             p_sub->str())
        "glob: star includes files")
    _AssertSameStrs(_Sl(p_base->glob("*/"))
        list(p_base->join("a")->str() p_sub->str())
        "glob: trailing slash dirs only")
    _AssertSameStrs(_Sl(p_base->glob("a/"))
        list(p_base->join("a")->str())
        "glob: literal trailing slash")
    _AssertSameStrs(_Sl(p_base->glob("hello.txt/"))
        nil
        "glob: file with trailing slash empty")
    _AssertSameStrs(_Sl(p_base->glob("*/*"))
        list(p_base->join("a/b")->str() p_f->str())
        "glob: two levels")
    _AssertSameStrs(_Sl(p_base->glob("**/c"))
        list(p_base->join("a/b/c")->str())
        "glob: recursive literal")
    _AssertSameStrs(_Sl(p_base->glob("b/*"))
        nil
        "glob: missing literal dir empty")
    _AssertSameStrs(_Sl(p_base->glob("[z-a]*"))
        nil
        "glob: descending range never matches")
    _AssertSameStrs(_Sl(p_base->glob("sub/../hello.txt"))
        list(p_base->join("sub/../hello.txt")->str())
        "glob: dotdot segment textual")
    _AssertSameStrs(_Sl(p_base->glob(".."))
        list(p_base->join("..")->str())
        "glob: dotdot terminal")
    _AssertError(lambda(() p_base->glob(".") t)  "glob: dot pattern errors")
    _AssertSameStrs(_Sl(p_base->join("hello.txt")->glob("*"))
        nil
        "glob: file base empty")
    _AssertError(lambda(() p_base->glob("") t)  "glob: empty pattern errors")
    _AssertError(lambda(() p_base->glob("/abs/*") t)  "glob: absolute pattern errors")
    _AssertErrorMsg(lambda(() p_base->glob("/abs/*"))
        "ycPathLib::Path->glob:"  "glob: absolute pattern uses method prefix")
    _AssertErrorMsg(lambda(() p_base->glob("."))
        "ycPathLib::Path->glob:"  "glob: unacceptable pattern uses method prefix")
    let((r)
        r = errset(_Sl(p_base->glob("a**")) nil)
        _Assert(r  "glob: partial ** does not error")
        when(r
            _AssertSameStrs(car(r)
                list(p_base->join("a")->str())
                "glob: partial ** acts as single star")
        )
    )
    let((r)
        r = errset(_Sl(p_base->glob("**txt")) nil)
        _Assert(r  "glob: leading partial ** does not error")
        when(r
            _AssertSameStrs(car(r)
                list(p_base->join("hello.txt")->str())
                "glob: leading partial ** acts as single star")
        )
    )
    _AssertError(lambda(() p_base->rglob("/abs") t)  "rglob: absolute pattern errors")
    _AssertErrorMsg(lambda(() p_base->rglob("/abs"))
        "ycPathLib::Path->rglob:"  "rglob: absolute pattern uses method prefix")
    _AssertError(lambda(() p_base->glob("./") t)  "glob: dot-slash pattern errors")
    _AssertSameStrs(_Sl(p_base->glob("./hello.txt"))
        list(p_base->join("hello.txt")->str())
        "glob: dot segment dropped")
    _AssertSameStrs(_Sl(p_base->glob("[ab]"))
        list(p_base->join("a")->str())
        "glob: char class single")
    _AssertSameStrs(_Sl(p_base->glob("[!a]*"))
        list(p_base->join("hello.txt")->str() p_sub->str())
        "glob: negated char class")
    _AssertSameStrs(_Sl(p_base->glob("*.tx[ty]"))
        list(p_base->join("hello.txt")->str())
        "glob: char class")
    _AssertSameStrs(_Sl(p_base->glob("*.tx[yz]"))
        nil
        "glob: char class miss")
    _AssertSameStrs(_Sl(p_base->glob("sub/../hello.txt/.."))
        nil
        "glob: dotdot after file empty")
)

; --- glob: leading-dot names NOT special (pathlib aligned) ---
let((p_hf p_hd p_sub p_f)
    p_sub = p_base->join("sub")
    p_f = p_sub->join("deep.txt")
    p_hf = p_base->join(".hidden.txt")
    p_hd = p_base->join(".hdir")
    p_hf->writeText("h")
    p_hd->mkdir()
    p_hd->join("inner.txt")->writeText("i")

    _AssertSameStrs(_Sl(p_base->glob("*"))
        list(p_base->join("a")->str()
             p_base->join("hello.txt")->str()
             p_sub->str()
             p_hf->str()
             p_hd->str())
        "glob: star matches leading-dot names too")
    _AssertSameStrs(_Sl(p_base->glob(".*"))
        list(p_hf->str() p_hd->str())
        "glob: dot-star matches leading-dot names")
    _AssertSameStrs(_Sl(p_base->glob("**"))
        list(p_base->str()
             p_base->join("a")->str()
             p_base->join("a/b")->str()
             p_base->join("a/b/c")->str()
             p_sub->str()
             p_hd->str()
             p_base->join("hello.txt")->str()
             p_f->str()
             p_hf->str()
             p_hd->join("inner.txt")->str())
        "glob: ** sees dot dirs, dot files and nested files")
    _AssertSameStrs(_Sl(p_base->glob("**/"))
        list(p_base->str()
             p_base->join("a")->str()
             p_base->join("a/b")->str()
             p_base->join("a/b/c")->str()
             p_sub->str()
             p_hd->str())
        "glob: **/ dirs only including dot dirs")
    _AssertSameStrs(_Sl(p_base->rglob("*.txt"))
        list(p_base->join("hello.txt")->str()
             p_f->str()
             p_hf->str()
             p_hd->join("inner.txt")->str())
        "rglob: includes leading-dot names")
    _AssertSameStrs(_Sl(p_base->glob("**/*.txt"))
        list(p_base->join("hello.txt")->str()
             p_f->str()
             p_hf->str()
             p_hd->join("inner.txt")->str())
        "glob: **/*.txt includes leading-dot dir contents")
    _Assert(length(_Sl(p_base->iterdir())) == 5  "iterdir: includes leading-dot names")
)

; --- module entry ---
let((p_wd)
    p_wd = ycPathLib::Cwd()
    _Assert(p_wd->isAbsolute()  "cwd: absolute")
    _Assert(p_wd->exists()  "cwd: exists")
    _Assert(p_wd->str() == _S(getWorkingDir())  "cwd: matches getWorkingDir")
)
let((home)
    home = getShellEnvVar("HOME")
    when(stringp(home) && home != ""
        _Assert(ycPathLib::Home()->str() == _S(home)  "home: matches HOME env")
    )
)

; --- readable / writable / executable ---
let((p_f p_miss)
    p_f = p_base->join("hello.txt")
    p_miss = p_base->join("no-such-entry")
    _Assert(p_f->readable()  "readable: file is readable")
    _Assert(p_f->writable()  "writable: file is writable")
    _Assert(!p_f->executable()  "executable: text file not executable")
    _Assert(p_base->executable()  "executable: dir is executable")
    _Assert(p_base->writable()  "writable: dir is writable")
    _Assert(!p_miss->readable()  "readable: missing -> nil")
    _Assert(!p_miss->writable()  "writable: missing -> nil")
    _Assert(!p_miss->executable()  "executable: missing -> nil")
)

; --- load / loadi ---
; The in-file runtime error path (load propagates, loadi does not) is NOT
; tested here: load holds the erroring file open, so deleting it on an NFS
; mount leaves an unremovable .nfsXXXX silly-rename file. That difference is
; left uncovered by this suite.
let((p_ok p_miss)
    p_ok = p_base->join("load_ok.il")
    p_miss = p_base->join("no-such-load.il")
    p_ok->writeText("_TestLoadSeen = t\n")

    _TestLoadSeen = nil
    _Assert(p_ok->load() == t  "load: returns t")
    _Assert(_TestLoadSeen == t  "load: executes the file")
    _TestLoadSeen = nil
    _Assert(p_ok->loadi() == t  "loadi: returns t")
    _Assert(_TestLoadSeen == t  "loadi: executes the file")
    _TestLoadSeen = nil
    _Assert(p_ok->load(nil) == t  "load: nil password == omitted")
    _Assert(p_ok->load("pw") == t  "load: password string accepted on plain file")

    _AssertError(lambda(() p_ok->load(42) t)  "load: non-string password errors")
    _AssertError(lambda(() p_ok->loadi(42) t)  "loadi: non-string password errors")
    _AssertError(lambda(() p_miss->load() t)  "load: missing file errors")
    _AssertError(lambda(() p_miss->loadi() t)  "loadi: missing file errors")
    _AssertError(lambda(() p_base->load() t)  "load: directory errors")
    _AssertError(lambda(() p_base->loadi() t)  "loadi: directory errors")

    p_ok->unlink()
)

; --- rename ---
let((p_src p_dst)
    p_src = p_base->join("hello.txt")
    p_dst = p_base->join("renamed.txt")
    p_src->rename(p_dst)
    _Assert(!p_src->exists() && p_dst->exists()  "rename: moves file")
    p_dst->rename(p_src)
    _Assert(p_src->exists() && !p_dst->exists()  "rename: moves file back")
    _AssertError(lambda(() p_src->rename(42) t)  "rename: bad target errors")
    _AssertError(lambda(() p_base->join("ghost.txt")->rename(p_src->str()) t)  "rename: missing source errors")
    _AssertError(lambda(() p_src->rename(p_base->join("a")->str()) t)  "rename: target dir errors")
)

; --- touch ---
; CPython Path.touch() bumps mtime via os.utime on existing files. The old
; outfile("a")+close-without-write form left st_mtime unchanged on POSIX, so
; touch() now shells out to touch(1) (like rename uses mv).
; system("sleep 1.1") avoids a false pass from whole-second mtime resolution;
; SKILL has no sleep builtin, so this shells out like the rm/ln calls above.
let((p_t before after)
    p_t = p_base->join("touched.txt")
    p_t->touch()
    _Assert(p_t->exists() && p_t->isFile()  "touch: creates file")
    p_t->writeText("keep")
    p_t->touch()
    _Assert(p_t->readText() == "keep"  "touch: preserves content")
    _AssertError(lambda(() p_base->touch() t)  "touch: directory errors")
    before = p_t->mtime()
    system("sleep 1.1")
    p_t->touch()
    after = p_t->mtime()
    _Assert(after > before  "touch: updates mtime of existing file (CPython updates)")
    _Assert(p_t->readText() == "keep"  "touch: content preserved after mtime bump")
)
when(isFileName("/proc/version")
    _TestErrorBegin("touch on an unwritable target")
    _AssertError(lambda(() _P("/proc/version")->touch() t)  "touch: unwritable target errors")
    _TestErrorEnd()
)

; --- tilde expansion in shell-based methods ---
let((home tmp_home p_src p_dst res)
    home = getShellEnvVar("HOME")
    tmp_home = p_base->join("home")->absolute()
    tmp_home->mkdir(?existOk t)
    setShellEnvVar("HOME" tmp_home->str())
    p_src = _P("~/touch.txt")
    p_dst = _P("~/renamed.txt")
    res = errset(p_src->touch() nil)
    _Assert(res  "touch: tilde expands to HOME")
    _Assert(tmp_home->join("touch.txt")->exists()
        "touch: tilde target created under HOME")
    res = errset(p_src->rename(p_dst) nil)
    _Assert(res  "rename: tilde expands to HOME")
    _Assert(tmp_home->join("renamed.txt")->exists()
        && !tmp_home->join("touch.txt")->exists()
        "rename: tilde moves under HOME")
    system(lsprintf("rm -rf %s" ycPathLib::ShellQuote(tmp_home->str())))
    setShellEnvVar("HOME" home)
)

; --- open ---
let((port)
    port = p_base->join("hello.txt")->open(?mode "r")
    _Assert(className(port) == 'ycIO::Port  "open: read mode returns ycIO::Port")
    when(port
        port->close()
    )
    _AssertError(lambda(() p_base->join("hello.txt")->open(?mode "b") t)  "open: invalid mode errors")
    _AssertError(lambda(() p_base->join("missing.txt")->open(?mode "r") t)  "open: missing file errors")
    _AssertErrorMsg(lambda(() _P("/proc/version")->open(?mode "w"))
        "ycPathLib::Path->open:"  "open: io failure uses pathlib prefix")
)

; --- resolve (real files, symlink safe) ---
let((p_f)
    p_f = p_base->join("hello.txt")
    _Assert(p_base->join("sub")->join("..")->join("hello.txt")->resolve()->str()
        == p_f->resolve()->str()
        "resolve: collapses dotdot on real paths")
    _Assert(_P("/")->resolve()->str() == "/"  "resolve: root")
)

; --- unlink ---
let((p_t)
    p_t = p_base->join("touched.txt")
    p_t->unlink()
    _Assert(!p_t->exists()  "unlink: removes file")
    _AssertError(lambda(() p_t->unlink() t)  "unlink: missing file errors")
    p_t->unlink(?missingOk t)
    _Assert(!p_t->exists()  "unlink: missingOk silent")
    _AssertError(lambda(() p_base->unlink() t)  "unlink: directory errors")
)

; --- rmdir ---
let((p_bc)
    p_bc = p_base->join("a")->join("b")
    _AssertError(lambda(() p_bc->rmdir() t)  "rmdir: non-empty errors")
    p_bc->join("c")->rmdir()
    _Assert(!p_bc->join("c")->exists()  "rmdir: removes empty dir")
    _AssertError(lambda(() p_bc->join("c")->rmdir() t)  "rmdir: missing dir errors")
    _AssertError(lambda(() p_base->join("no-such-dir")->rmdir() t)  "rmdir: never-created errors")
)

; --- symlink ---
let((p_tfile p_tdir p_link p_moved p_dirlnk p_broken)
    p_tfile = p_base->join("hello.txt")
    p_tdir = p_base->join("sub")
    p_link = p_base->join("link.txt")
    p_moved = p_base->join("moved.txt")
    p_dirlnk = p_base->join("linkdir")
    system(lsprintf("ln -s hello.txt %s/link.txt" p_base->str()))
    system(lsprintf("ln -s sub %s/linkdir" p_base->str()))
    _Assert(p_link->isSymlink() && p_dirlnk->isSymlink()  "symlink: isSymlink true")
    _Assert(!p_tfile->isSymlink() && !p_tdir->isSymlink()  "symlink: real entries not symlink")
    _Assert(p_link->exists() && p_link->isFile()  "symlink: follows to target file")
    _Assert(p_link->size() == p_tfile->size()  "symlink: size follows target")
    _Assert(p_link->mtime() == p_tfile->mtime()  "symlink: mtime follows target")
    _AssertSameStrs(_Sl(p_base->glob("**"))
        list(p_base->str()
             p_base->join("a")->str()
             p_base->join("a/b")->str()
             p_tdir->str()
             p_dirlnk->str()
             p_tfile->str()
             p_tdir->join("deep.txt")->str()
             p_base->join(".hidden.txt")->str()
             p_base->join(".hdir")->str()
             p_base->join(".hdir/inner.txt")->str()
             p_link->str())
        "symlink: glob ** yields link dir entry but does not enter it")
    _AssertSameStrs(_Sl(p_base->glob("**/"))
        list(p_base->str()
             p_base->join("a")->str()
             p_base->join("a/b")->str()
             p_tdir->str()
             p_base->join(".hdir")->str())
        "symlink: **/ dirs only excludes link dir")
    _AssertSameStrs(_Sl(p_base->glob("linkdir/*"))
        list(p_base->join("linkdir/deep.txt")->str())
        "symlink: explicit component enters link dir")
    _AssertSameStrs(_Sl(p_base->rglob("*.txt"))
        list(p_tfile->str()
             p_tdir->join("deep.txt")->str()
             p_link->str()
             p_base->join(".hidden.txt")->str()
             p_base->join(".hdir/inner.txt")->str())
        "symlink: rglob sees link name but not link dir contents")
    _Assert(p_link->readable()  "readable: symlink follows target")
    _Assert(p_link->writable()  "writable: symlink follows target")
    _Assert(!p_link->executable()  "executable: symlink follows target (not executable)")
    p_link->rename(p_moved)
    _Assert(!p_link->isSymlink() && p_moved->isSymlink() && p_tfile->exists()  "symlink: rename moves the link itself")
    p_moved->unlink()
    _Assert(!p_moved->exists() && !p_moved->isSymlink() && p_tfile->exists()  "symlink: unlink removes link keeps target")
    p_broken = p_base->join("broken")
    system(lsprintf("ln -s no-such-target %s/broken" p_base->str()))
    _Assert(p_broken->isSymlink()  "symlink: broken link isSymlink")
    _Assert(!p_broken->exists()  "symlink: broken link exists false")
    _AssertError(lambda(() p_broken->size() t)  "symlink: broken link size errors")
    _AssertError(lambda(() p_broken->mtime() t)  "symlink: broken link mtime errors")
    _Assert(!p_broken->readable()  "readable: broken symlink -> nil")
    _Assert(!p_broken->writable()  "writable: broken symlink -> nil")
    _Assert(!p_broken->executable()  "executable: broken symlink -> nil")
)

; --- size() on a directory ---
; CPython Path.stat().st_size on a directory is a number (real dir size).
; size() only checks exists(), which is also true for directories, so the
; call returns the directory's real byte size (a number).
let((r)
    r = errset(p_base->size() nil)
    _Assert(r && numberp(car(r))  "size: directory returns a number (CPython stat().st_size)")
)

; --- dash-prefixed relative names ---
; 破折号文件名必须以相对形式传给 shell 才会触发选项解析；
; 在独立临时目录内执行，结束后恢复工作目录，避免碰到运行目录中的同名文件。
let((p_dash saved_dir)
    saved_dir = getWorkingDir()
    p_dash = p_base->join("dash")
    p_dash->mkdir()
    changeWorkingDir(p_dash->absolute()->str())
    unwindProtect(
        progn(
            _P("-n")->touch()
            _Assert(_P("-n")->exists()  "touch: dash-prefixed name is a file, not an option")
            _P("-n")->rename("-f")
            _Assert(_P("-f")->exists() && !_P("-n")->exists()  "rename: dash-prefixed names")
            _P("-f")->unlink()
            _Assert(!_P("-f")->exists()  "unlink: dash-prefixed name removed")
        )
        changeWorkingDir(saved_dir)
    )
    _Assert(getWorkingDir() == saved_dir  "dash fixture: working directory restored")
)

; --- cleanup ---
system(strcat("rm -rf " tmp))
_Assert(!p_base->exists()  "fixture: cleanup")

)  ; end let

_TestChildDone = t

; END
