;--------------------------
; Program  : ycTabulate tests(load.il)
; Language : Cadence Skill
;--------------------------

let((res path dir)
    res = errset(get_filename(piport) nil)
    path = when(res && car(res) && stringp(car(res)) && car(res) != ""
        car(res)
    )
    unless(path
        error("ycTabulate: can't determine the current file - load this file with an explicit path")
    )
    unless(pcreMatchp("^[~/]|^\\.{1,2}/" path)
        path = strcat("./" path)
    )
    dir = simplifyFilename(pcreReplace(pcreCompile("(?<=/)[^/]+/*$") path "" 0) t)
    unless(pcreMatchp("/$" dir)
        dir = strcat(dir "/")
    )
    unless(findNamespace("ycNamespace")
        loadi(strcat(dir "../../libs/registry.il"))
    )
    unless(findNamespace("ycPathLib")
        loadi(strcat(dir "../../libs/pathlib/load.il"))
    )
    unless(findNamespace("ycUtf8")
        loadi(strcat(dir "../../libs/utf8/load.il"))
    )
    unless(findNamespace("ycTextwrap")
        loadi(strcat(dir "../../libs/textwrap/load.il"))
    )
    when(findNamespace("ycTabulate") == nil || findSymbol("Render" ?namespace "ycTabulate") == nil || !fboundp(findSymbol("Render" ?namespace "ycTabulate"))
        loadi(strcat(dir "../../libs/tabulate/load.il"))
    )
    _TestDir = dir
    unless(fboundp('_TestRun)
        loadi(strcat(_TestDir "../kit.il"))
    )
    loadi(strcat(_TestDir "test_init.il"))
)

; END
