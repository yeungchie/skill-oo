;--------------------------
; Program  : ycTabulate tests(load.il)
; Language : Cadence Skill
;--------------------------

let((t_res t_self t_dir)
    t_res = errset(get_filename(piport) nil)
    t_self = when(t_res && car(t_res) && stringp(car(t_res)) && car(t_res) != ""
        car(t_res)
    )
    unless(t_self
        error("ycTabulate: can't determine the current file - load this file with an explicit path")
    )
    unless(pcreMatchp("^[~/]|^\\.{1,2}/" t_self)
        t_self = strcat("./" t_self)
    )
    t_dir = simplifyFilename(pcreReplace(pcreCompile("(?<=/)[^/]+/*$") t_self "" 0) t)
    unless(pcreMatchp("/$" t_dir)
        t_dir = strcat(t_dir "/")
    )
    unless(findNamespace("ycNamespace")
        loadi(strcat(t_dir "../../libs/registry.il"))
    )
    unless(findNamespace("ycPathLib")
        loadi(strcat(t_dir "../../libs/pathlib/load.il"))
    )
    unless(findNamespace("ycUtf8")
        loadi(strcat(t_dir "../../libs/utf8/load.il"))
    )
    unless(findNamespace("ycTextwrap")
        loadi(strcat(t_dir "../../libs/textwrap/load.il"))
    )
    when(findNamespace("ycTabulate") == nil || findSymbol("Render" ?namespace "ycTabulate") == nil || !fboundp(findSymbol("Render" ?namespace "ycTabulate"))
        loadi(strcat(t_dir "../../libs/tabulate/load.il"))
    )
    _TestDir = t_dir
    unless(fboundp('_TestRun)
        loadi(strcat(_TestDir "../kit.il"))
    )
    loadi(strcat(_TestDir "test_init.il"))
)

; END
